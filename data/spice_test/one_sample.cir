* One-sample transistor simulation

.include "C:/Users/hp/Desktop/DVD_project/data/spice_test/sample_model.pm"

.options gmin=1e-18 abstol=1e-18 reltol=1e-6 vntol=1e-9

.temp -23.2943278366

VDS d 0 DC 0.82852442715
VGS g 0 DC 0.863694498124
VSS s 0 DC 0.4483639596
VBS b 0 DC 0

M1 d g s b nmos L=1.6e-08 W=9.4760992663e-08

.control
op

let Id = -i(VDS)
let Ig = -i(VGS)
let Is = -i(VSS)
let Ib = -i(VBS)

print Id
print Ig
print Is
print Ib

quit
.endc

.end
